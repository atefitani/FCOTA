ADE simulation setup
Run mode: Single Run, Sweeps and Corners
Tests:
  FCOTA_project_PMOS_1: FCOTA_project/PMOS/schematic, simulator spectre
    Variables: LP = 425n; Vsd = 0.4; Vsg = 594m; WP = 1u
    Outputs: Vgs vs gm/Id; Current Density vs gm/Id; Vdsat vs gm/Id
