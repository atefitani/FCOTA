ADE simulation setup
Run mode: Single Run, Sweeps and Corners
Tests:
  Pre_Layout: FCOTA/tb_fcota_with_cmfb/schematic, simulator spectre
    Variables: Iref = 20u; Lcm = 600n; Lcmfb = 600n; VCN = 650m; VCP = 540m; VDD = 1.2; VdiffAC = 1; VICMdc = 300m; VREF = 500m; Ri = 500k
    Outputs: A_cl_dB; A_cl; BW; GBW; fu; Gain dB (plot); Gain mag (plot); Phase (plot)
  Post_Layout: FCOTA/tb_fcota_with_cmfb/schematic, simulator spectre
    Variables: Iref = 20u; Lcm = 600n; Lcmfb = 600n; VCN = 650m; VCP = 540m; VDD = 1.2; VdiffAC = 1; VICMdc = 300m; VREF = 500m; Ri = 500k
    Outputs: A_cl_dB; A_cl; BW; GBW; fu; Gain dB (plot); Gain mag (plot); Phase (plot)
Specs:
  Pre_Layout / A_cl_dB: > 6
  Post_Layout / A_cl_dB: > 6
  Pre_Layout / A_cl: > 2
  Post_Layout / A_cl: > 2
  Pre_Layout / BW: > 10M
  Pre_Layout / GBW: > 20M
  Post_Layout / BW: > 10M
  Post_Layout / GBW: > 20M
