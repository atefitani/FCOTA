ADE simulation setup
Run mode: Single Run, Sweeps and Corners
Tests:
  FCOTA_fcota_cmfb_tb__1: FCOTA/tb_fcota_cmfb_real_open/schematic, simulator spectre
    Variables: Iref = 20u; Lcm = 600n; Lcmfb = 600n; VCN = 650m; VCP = 540m; VDD = 1.2; VdiffAC = 1; VICMdc = 300m; VREF = 500m
    Outputs: Ao_dB; Ao; BW; GBW; fu; Gain dB (plot); Gain mag (plot); Phase (plot)
