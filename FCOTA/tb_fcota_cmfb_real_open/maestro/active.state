ADE simulation setup
Test FCOTA_fcota_cmfb_tb__1: FCOTA/tb_fcota_cmfb_real_open/schematic, simulator spectre
  Models: /home/vlsi/cadence/UMC/65/_G-01-LOGIC_MIXED_MODE65N-SP_LOW_K/Designkits/Cadence_IC6/umc65sp/../Models/Spectre/l65sp_v132.lib.scs[tt_sp_lvt11, tt_sp_rvt11, tt_sp_hvt11, tt_sp_shvt11, tt_sp_io18, tt_sp_io25od33, tt_sp_io33, tt_sp_nvt11, tt_sp_nvt18, tt_sp_nvt25od33, tt_sp_nvt33, tt_sp_ncap11, tt_sp_ncap18, tt_sp_ncap25, tt_sp_ncap33, tt_sp_diode, tt_sp_bjt, tt_65_momcaps, tt_sp_res], /home/vlsi/cadence/UMC/65/_G-01-LOGIC_MIXED_MODE65N-SP_LOW_K/Designkits/Cadence_IC6/umc65sp/../Models/Spectre/L65_MIMCAPS_20F_KF_V101_RF.lib.scs[tt], /home/vlsi/cadence/UMC/65/_G-01-LOGIC_MIXED_MODE65N-SP_LOW_K/Designkits/Cadence_IC6/umc65sp/../Models/Spectre/L65SP_RNNPO_VT01_RF.lib.scs[typ], /home/vlsi/cadence/UMC/65/_G-01-LOGIC_MIXED_MODE65N-SP_LOW_K/Designkits/Cadence_IC6/umc65sp/../Models/Spectre/L65SP_RNPPO_VT01_RF.lib.scs[typ], /home/vlsi/cadence/UMC/65/_G-01-LOGIC_MIXED_MODE65N-SP_LOW_K/Designkits/Cadence_IC6/umc65sp/../Models/Spectre/L65SP_RNHR_VT01_RF.lib.scs[typ], /home/vlsi/cadence/UMC/65/_G-01-LOGIC_MIXED_MODE65N-SP_LOW_K/Designkits/Cadence_IC6/umc65sp/../Models/Spectre/L65SP_RVT10_RF_V101.lib.scs[tt], /home/vlsi/cadence/UMC/65/_G-01-LOGIC_MIXED_MODE65N-SP_LOW_K/Designkits/Cadence_IC6/umc65sp/../Models/Spectre/L65SP_IO18_V021_RF.lib.scs[tt], /home/vlsi/cadence/UMC/65/_G-01-LOGIC_MIXED_MODE65N-SP_LOW_K/Designkits/Cadence_IC6/umc65sp/../Models/Spectre/L65SP_IO25_V101_RF.lib.scs[tt], /home/vlsi/cadence/UMC/65/_G-01-LOGIC_MIXED_MODE65N-SP_LOW_K/Designkits/Cadence_IC6/umc65sp/../Models/Spectre/L65SP_IO33_V101_RF.lib.scs[tt], /home/vlsi/cadence/UMC/65/_G-01-LOGIC_MIXED_MODE65N-SP_LOW_K/Designkits/Cadence_IC6/umc65sp/../Models/Spectre/L65_pad_rf_V101.lib.scs[typ], /home/vlsi/cadence/UMC/65/_G-01-LOGIC_MIXED_MODE65N-SP_LOW_K/Designkits/Cadence_IC6/umc65sp/../Models/Spectre/L65SP_VARMIS11_V101_RF.lib.scs[typ], /home/vlsi/cadence/UMC/65/_G-01-LOGIC_MIXED_MODE65N-SP_LOW_K/Designkits/Cadence_IC6/umc65sp/../Models/Spectre/L65SP_VARMIS18_V021_RF.LIB.SCS[typ], /home/vlsi/cadence/UMC/65/_G-01-LOGIC_MIXED_MODE65N-SP_LOW_K/Designkits/Cadence_IC6/umc65sp/../Models/Spectre/L65SP_VARMIS25_RF_V101.lib.scs[typ], /home/vlsi/cadence/UMC/65/_G-01-LOGIC_MIXED_MODE65N-SP_LOW_K/Designkits/Cadence_IC6/umc65sp/../Models/Spectre/L65SP_VARMIS33_V101_RF.lib.scs[typ], /home/vlsi/cadence/UMC/65/_G-01-LOGIC_MIXED_MODE65N-SP_LOW_K/Designkits/Cadence_IC6/umc65sp/../Models/Spectre/momcaps_array_vp3_rfvcl_V101.lib.scs[typ], /home/vlsi/cadence/UMC/65/_G-01-LOGIC_MIXED_MODE65N-SP_LOW_K/Designkits/Cadence_IC6/umc65sp/../Models/Spectre/momcaps_array_vp4_rfvcl_V101.lib.scs[typ], /home/vlsi/cadence/UMC/65/_G-01-LOGIC_MIXED_MODE65N-SP_LOW_K/Designkits/Cadence_IC6/umc65sp/../Models/Spectre/momcaps_array_vp5_rfvcl_V101.lib.scs[typ]
  Variables: Iref = 20u; Lcm = 600n; Lcmfb = 600n; VCN = 650m; VCP = 540m; VDD = 1.2; VdiffAC = 1; VICMdc = 300m; VREF = 500m
  Temperature: 27
  Analysis ac: start=1 stop=10G dec=10
  Analysis dc: (saves the operating point)
  Output Ao_dB = dB20(ymax(mag(VF("/VOUTD"))))
  Output Ao = ymax(mag(VF("/VOUTD")))
  Output BW = bandwidth(VF("/VOUTD") 3 "low")
  Output GBW = (Ao * BW)
  Output fu = unityGainFreq(VF("/VOUTD"))
  Output Gain dB (plot) = dB20(v("/VOUTD" ?result "ac"))
  Output Gain mag (plot) = vfreq("ac" "/VOUTD")
  Output Phase (plot) = phaseDegUnwrapped(vfreq("ac" "/VOUTD"))
  Signals: /VOUTD
Run mode: Single Run, Sweeps and Corners
