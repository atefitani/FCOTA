ADE simulation setup
Run mode: Single Run, Sweeps and Corners
Tests:
  FCOTA_fcota_cmfb_closed_1: FCOTA/tb_fcota_cmfb_real_closed/schematic, simulator spectre
    Variables: Iref = 20u; Lcm = 600n; Lcmfb = 600n; VCN = 650m; VCP = 540m; VDD = 1.2; VdiffAC = 1; VICMdc = 300m; VREF = 500m; Lcasc = 500n; Ri = 500k
    Outputs: Ac_dB; Gain dB (plot); Ac; BW; GBW; fu; Phase (plot); "/VON"; "/VIN"; /V; Input_Swing; Output_Swing; Gain from swing
Specs:
  FCOTA_fcota_cmfb_closed_1 / Ac: > 2
  FCOTA_fcota_cmfb_closed_1 / GBW: > 20M
  FCOTA_fcota_cmfb_closed_1 / Ac_dB: > 6.02
  FCOTA_fcota_cmfb_closed_1 / BW: > 10M
  FCOTA_fcota_cmfb_closed_1 / fu: > 20M
  FCOTA_fcota_cmfb_closed_1 / Gain from swing: > 2
  FCOTA_fcota_cmfb_closed_1 / Output_Swing: > 600m
