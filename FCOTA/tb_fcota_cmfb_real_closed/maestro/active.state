ADE simulation setup
Test FCOTA_fcota_cmfb_closed_1: FCOTA/tb_fcota_cmfb_real_closed/schematic, simulator spectre
  Models: /home/vlsi/cadence/UMC/65/_G-01-LOGIC_MIXED_MODE65N-SP_LOW_K/Designkits/Cadence_IC6/umc65sp/../Models/Spectre/l65sp_v132.lib.scs[tt_sp_lvt11, tt_sp_rvt11, tt_sp_hvt11, tt_sp_shvt11, tt_sp_io18, tt_sp_io25od33, tt_sp_io33, tt_sp_nvt11, tt_sp_nvt18, tt_sp_nvt25od33, tt_sp_nvt33, tt_sp_ncap11, tt_sp_ncap18, tt_sp_ncap25, tt_sp_ncap33, tt_sp_diode, tt_sp_bjt, tt_65_momcaps, tt_sp_res], /home/vlsi/cadence/UMC/65/_G-01-LOGIC_MIXED_MODE65N-SP_LOW_K/Designkits/Cadence_IC6/umc65sp/../Models/Spectre/L65_MIMCAPS_20F_KF_V101_RF.lib.scs[tt], /home/vlsi/cadence/UMC/65/_G-01-LOGIC_MIXED_MODE65N-SP_LOW_K/Designkits/Cadence_IC6/umc65sp/../Models/Spectre/L65SP_RNNPO_VT01_RF.lib.scs[typ], /home/vlsi/cadence/UMC/65/_G-01-LOGIC_MIXED_MODE65N-SP_LOW_K/Designkits/Cadence_IC6/umc65sp/../Models/Spectre/L65SP_RNPPO_VT01_RF.lib.scs[typ], /home/vlsi/cadence/UMC/65/_G-01-LOGIC_MIXED_MODE65N-SP_LOW_K/Designkits/Cadence_IC6/umc65sp/../Models/Spectre/L65SP_RNHR_VT01_RF.lib.scs[typ], /home/vlsi/cadence/UMC/65/_G-01-LOGIC_MIXED_MODE65N-SP_LOW_K/Designkits/Cadence_IC6/umc65sp/../Models/Spectre/L65SP_RVT10_RF_V101.lib.scs[tt], /home/vlsi/cadence/UMC/65/_G-01-LOGIC_MIXED_MODE65N-SP_LOW_K/Designkits/Cadence_IC6/umc65sp/../Models/Spectre/L65SP_IO18_V021_RF.lib.scs[tt], /home/vlsi/cadence/UMC/65/_G-01-LOGIC_MIXED_MODE65N-SP_LOW_K/Designkits/Cadence_IC6/umc65sp/../Models/Spectre/L65SP_IO25_V101_RF.lib.scs[tt], /home/vlsi/cadence/UMC/65/_G-01-LOGIC_MIXED_MODE65N-SP_LOW_K/Designkits/Cadence_IC6/umc65sp/../Models/Spectre/L65SP_IO33_V101_RF.lib.scs[tt], /home/vlsi/cadence/UMC/65/_G-01-LOGIC_MIXED_MODE65N-SP_LOW_K/Designkits/Cadence_IC6/umc65sp/../Models/Spectre/L65_pad_rf_V101.lib.scs[typ], /home/vlsi/cadence/UMC/65/_G-01-LOGIC_MIXED_MODE65N-SP_LOW_K/Designkits/Cadence_IC6/umc65sp/../Models/Spectre/L65SP_VARMIS11_V101_RF.lib.scs[typ], /home/vlsi/cadence/UMC/65/_G-01-LOGIC_MIXED_MODE65N-SP_LOW_K/Designkits/Cadence_IC6/umc65sp/../Models/Spectre/L65SP_VARMIS18_V021_RF.LIB.SCS[typ], /home/vlsi/cadence/UMC/65/_G-01-LOGIC_MIXED_MODE65N-SP_LOW_K/Designkits/Cadence_IC6/umc65sp/../Models/Spectre/L65SP_VARMIS25_RF_V101.lib.scs[typ], /home/vlsi/cadence/UMC/65/_G-01-LOGIC_MIXED_MODE65N-SP_LOW_K/Designkits/Cadence_IC6/umc65sp/../Models/Spectre/L65SP_VARMIS33_V101_RF.lib.scs[typ], /home/vlsi/cadence/UMC/65/_G-01-LOGIC_MIXED_MODE65N-SP_LOW_K/Designkits/Cadence_IC6/umc65sp/../Models/Spectre/momcaps_array_vp3_rfvcl_V101.lib.scs[typ], /home/vlsi/cadence/UMC/65/_G-01-LOGIC_MIXED_MODE65N-SP_LOW_K/Designkits/Cadence_IC6/umc65sp/../Models/Spectre/momcaps_array_vp4_rfvcl_V101.lib.scs[typ], /home/vlsi/cadence/UMC/65/_G-01-LOGIC_MIXED_MODE65N-SP_LOW_K/Designkits/Cadence_IC6/umc65sp/../Models/Spectre/momcaps_array_vp5_rfvcl_V101.lib.scs[typ]
  Variables: Ri = 500k; Lcasc = 500n; Iref = 20u; Lcm = 600n; Lcmfb = 600n; VCN = 650m; VCP = 540m; VDD = 1.2; VdiffAC = 1; VICMdc = 300m; VREF = 500m
  Temperature: 27
  Initial conditions: /net2 = 0
  Analysis tran: stop=30u maxstep=0.1u
  Analysis ac: start=1 stop=10G dec=10
  Analysis dc: (saves the operating point)
  Output Ac_dB = dB20(value(mag(VF("/VOUTD")) 0)) (unticked)
  Output Ac = value(mag(VF("/VOUTD")) 0) (unticked)
  Output BW = bandwidth(VF("/VOUTD") 3 "low") (unticked)
  Output GBW = (Ac * BW) (unticked)
  Output fu = unityGainFreq(VF("/VOUTD")) (unticked)
  Output Gain dB (plot) = db20(v("/VOUTD" ?result "ac")) (unticked)
  Output Phase (plot) = phaseDegUnwrapped(vfreq("ac" "/VOUTD")) (unticked)
  Output Input_Swing = peakToPeak(v("/VID" ?result "tran"))
  Output Output_Swing = peakToPeak(v("/VOUTD" ?result "tran"))
  Output Gain from swing = (Output_Swing / Input_Swing)
  Signals: /VOUTD, /VID
Run mode: Single Run, Sweeps and Corners
Specs:
  FCOTA_fcota_cmfb_closed_1 / Ac: > 2
  FCOTA_fcota_cmfb_closed_1 / GBW: > 20M
  FCOTA_fcota_cmfb_closed_1 / Ac_dB: > 6.02
  FCOTA_fcota_cmfb_closed_1 / BW: > 10M
  FCOTA_fcota_cmfb_closed_1 / fu: > 20M
  FCOTA_fcota_cmfb_closed_1 / Gain from swing: > 2
  FCOTA_fcota_cmfb_closed_1 / Output_Swing: > 600m
