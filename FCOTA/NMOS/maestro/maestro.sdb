ADE simulation setup
Run mode: Single Run, Sweeps and Corners
Tests:
  FCOTA_project_NMOS_1: FCOTA_project/NMOS/schematic, simulator spectre
    Variables: LN = 425n; Vds = 0.4; Vgs = 500m; WN = 10u
    Outputs: waveVsWave(?x getData("PM0:gmoverid" ?result "dc") ?y v("PM0:vgs" ?result "dc")); Vgs vs gm/Id; waveVsWave(?x getData("PM0:gmoverid" ?result "dc") ?y (getData("PM0:id" ?result "dc") / pv("/WP" "value" ?result "variables"))); Current Density vs gm/Id; waveVsWave(?x getData("PM0:gmoverid" ?result "dc") ?y v("PM0:vdsat" ?result "dc")); Vdsat vs gm/Id
